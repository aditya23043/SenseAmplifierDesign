* File: netlist.pex.spi
* Created: Thu Apr  9 16:03:34 2026
* Program "Calibre xRC"
* Version "v2013.1_34.21"
*
.include "netlist.pex.spi.pex"
.subckt senseamp  BL BLB Q QB SAF SAT SAen gnd pch vdd
*
* BLB	BLB
* gnd	gnd
* vdd	vdd
* BL	BL
* Q	Q
* SAT	SAT
* QB	QB
* pch	pch
* SAF	SAF
* SAen	SAen
XM0 N_SAF_XM0_d N_SAen_XM0_g N_BL_XM0_s N_vdd_X19_noxref_minus psvtlp L=0.06
+ W=1.8 NFING=1 M=1 AS=0.315 AD=0.315 PS=2.15 PD=2.15 PO2ACT=0.175 NGCON=1 lpe=3
XM14 N_Q_XM14_d N_SAF_XM14_g N_vdd_XM14_s N_vdd_X18_noxref_minus psvtlp L=0.06
+ W=0.2 NFING=1 M=1 AS=0.035 AD=0.02 PS=0.55 PD=0.2 PO2ACT=0.295796 NGCON=1
+ lpe=3
XM15 N_Q_XM14_d N_QB_XM15_g N_vdd_XM15_s N_vdd_X18_noxref_minus psvtlp L=0.06
+ W=0.2 NFING=1 M=1 AS=0.02 AD=0.02 PS=0.2 PD=0.2 PO2ACT=0.535088 NGCON=1 lpe=3
XM2 N_SAF_XM2_d N_SAT_XM2_g N_vdd_XM2_s N_vdd_X19_noxref_minus psvtlp L=0.06
+ W=1.6 NFING=1 M=1 AS=0.16 AD=0.28 PS=0.2 PD=1.95 PO2ACT=0.24959 NGCON=1 lpe=3
XM10 N_SAF_XM10_d N_pch_XM10_g N_vdd_XM10_s N_vdd_X19_noxref_minus psvtlp L=0.06
+ W=0.135 NFING=1 M=1 AS=0.0135 AD=0.023625 PS=0.2 PD=0.485 PO2ACT=0.279598
+ NGCON=1 lpe=3
XM18 N_QB_XM18_d N_SAT_XM18_g N_vdd_XM15_s N_vdd_X18_noxref_minus psvtlp L=0.06
+ W=0.2 NFING=1 M=1 AS=0.02 AD=0.02 PS=0.2 PD=0.2 PO2ACT=0.535088 NGCON=1 lpe=3
XM3 N_SAT_XM3_d N_SAF_XM3_g N_vdd_XM2_s N_vdd_X19_noxref_minus psvtlp L=0.06
+ W=1.6 NFING=1 M=1 AS=0.16 AD=0.28 PS=0.2 PD=1.95 PO2ACT=0.24959 NGCON=1 lpe=3
XM9 N_SAT_XM9_d N_pch_XM9_g N_vdd_XM10_s N_vdd_X19_noxref_minus psvtlp L=0.06
+ W=0.135 NFING=1 M=1 AS=0.0135 AD=0.0135 PS=0.2 PD=0.2 PO2ACT=0.435 NGCON=1
+ lpe=3
XM16 N_QB_XM18_d N_Q_XM16_g N_vdd_XM16_s N_vdd_X18_noxref_minus psvtlp L=0.06
+ W=0.2 NFING=1 M=1 AS=0.035 AD=0.02 PS=0.55 PD=0.2 PO2ACT=0.295796 NGCON=1
+ lpe=3
XM8 N_SAT_XM9_d N_pch_XM8_g N_SAF_XM8_s N_vdd_X19_noxref_minus psvtlp L=0.06
+ W=0.135 NFING=1 M=1 AS=0.023625 AD=0.0135 PS=0.485 PD=0.2 PO2ACT=0.279598
+ NGCON=1 lpe=3
XM7 N_SAT_XM7_d N_SAen_XM7_g N_BLB_XM7_s N_vdd_X19_noxref_minus psvtlp L=0.06
+ W=1.8 NFING=1 M=1 AS=0.315 AD=0.315 PS=2.15 PD=2.15 PO2ACT=0.175 NGCON=1 lpe=3
XM12 N_Q_XM12_d N_SAF_XM12_g net059 N_gnd_X18_noxref_plus nsvtlp L=0.06 W=0.2
+ NFING=1 M=1 AS=0.02 AD=0.035 PS=0.2 PD=0.55 PO2ACT=0.295796 NGCON=1 lpe=1
XM6 net059 N_QB_XM6_g N_gnd_XM6_s N_gnd_X18_noxref_plus nsvtlp L=0.06 W=0.2
+ NFING=1 M=1 AS=0.02 AD=0.02 PS=0.2 PD=0.2 PO2ACT=0.535088 NGCON=1 lpe=1
XM1 N_SAF_XM1_d N_SAT_XM1_g N_net019_XM1_s N_gnd_X18_noxref_plus nsvtlp L=0.06
+ W=2.4 NFING=1 M=1 AS=0.24 AD=0.42 PS=0.2 PD=2.75 PO2ACT=0.24959 NGCON=1 lpe=3
XM13 net058 N_SAT_XM13_g N_gnd_XM6_s N_gnd_X18_noxref_plus nsvtlp L=0.06 W=0.2
+ NFING=1 M=1 AS=0.02 AD=0.02 PS=0.2 PD=0.2 PO2ACT=0.535088 NGCON=1 lpe=1
XM4 N_SAT_XM4_d N_SAF_XM4_g N_net019_XM1_s N_gnd_X18_noxref_plus nsvtlp L=0.06
+ W=2.4 NFING=1 M=1 AS=0.24 AD=0.42 PS=0.2 PD=2.75 PO2ACT=0.24959 NGCON=1 lpe=3
XM17 N_QB_XM17_d N_Q_XM17_g net058 N_gnd_X18_noxref_plus nsvtlp L=0.06 W=0.2
+ NFING=1 M=1 AS=0.02 AD=0.035 PS=0.2 PD=0.55 PO2ACT=0.295796 NGCON=1 lpe=1
XM5 N_net019_XM5_d N_SAen_XM5_g N_gnd_XM5_s N_gnd_X18_noxref_plus nsvtlp L=0.06
+ W=2.8 NFING=1 M=1 AS=0.49 AD=0.49 PS=3.15 PD=3.15 PO2ACT=0.175 NGCON=1 lpe=3
*
.include "netlist.pex.spi.senseamp.pxi"
*
.ends
*
*
