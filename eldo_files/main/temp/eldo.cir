*
* Have atleast 3 lines of space for some reason otherwise eldo glitches out
*

.include /modelfile_65nm/minNminP.cir
.include netlist.src.net

X1 BL BLB SAen gnd pch vdd senseamp

.param SUPPLY = 1.08
.param tend = 10u
.TEMP = -40

* Output Load

* POWER
v_dd vdd 0 SUPPLY
v_gnd gnd 0 0
v_bl BL 0 SUPPLY
v_blb BLB 0 {SUPPLY-0.2}
v_pch pch 0 SUPPLY

* (low_voltage high_voltage starting_delay rise_time fall_time on_pulse_width time_period)
v1 SAen gnd PULSE (0 {SUPPLY} 10p 10p 10p 100n 200n)

.probe v(*) v(X1.*)
.probe i(*)

.tran 1p tend

.end
